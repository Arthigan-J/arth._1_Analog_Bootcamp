** sch_path: /home/arthcodez/arth._1_Analog_Bootcamp/analog/schematics/tb_dc_analysis.sch
**.subckt tb_dc_analysis
R1 VCM Vin+ 1M m=1
R2 VCM Vin- 1M m=1
VDD VDD GND 1.8
VCM VCM GND 0.9
VDIFF Vin+ Vin- 0
VSS VSS GND 0
x1 VDD Vin- Vin+ net1 VSS bootcamp_opamp
**** begin user architecture code

.dc vdiff -10m 10m 0.1m
.save all

.param mc_mm_switch=0
.param mc_pr_switch=0
.include /home/arthcodez/.volare/sky130A/libs.tech/ngspice/corners/tt.spice
.include /home/arthcodez/.volare/sky130A/libs.tech/ngspice/r+c/res_typical__cap_typical.spice
.include /home/arthcodez/.volare/sky130A/libs.tech/ngspice/r+c/res_typical__cap_typical__lin.spice
.include /home/arthcodez/.volare/sky130A/libs.tech/ngspice/corners/tt/specialized_cells.spice

**** end user architecture code
**.ends

* expanding   symbol:  bootcamp_opamp.sym # of pins=5
** sym_path: /home/arthcodez/arth._1_Analog_Bootcamp/analog/symbols/bootcamp_opamp.sym
** sch_path: /home/arthcodez/arth._1_Analog_Bootcamp/analog/symbols/bootcamp_opamp.sch
.subckt bootcamp_opamp Vdd Vin- Vin+ Vout Vss
.ends

.GLOBAL GND
.GLOBAL VDD
.GLOBAL VCM
.GLOBAL VSS
.end
